.param wnd=1u wpd=1u

.option scale=1

.subckt dti_55g_6t_nor2x1 VDD VSS Z B A
mn1 Z A VSS VSS nch l=0.06u w=0.23u
mn2 Z B VSS VSS nch l=0.06u w=0.23u
mp1 Z A N1N71 VDD pch l=0.06u w=0.23u
mp2 N1N71 B VDD VDD pch l=0.06u w=0.23u
.ends
