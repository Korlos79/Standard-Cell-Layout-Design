.param wnd=1u wpd=1u

.option scale=1

.subckt dti_55g_6t_invx1 VDD VSS A Z
mn1 Z A VSS VSS nch l=0.06u w=0.23u
mp1 Z A VDD VDD pch l=0.06u w=0.23u
.ends
